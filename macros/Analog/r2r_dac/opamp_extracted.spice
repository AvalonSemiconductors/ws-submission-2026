* NGSPICE file created from opamp_extracted.ext - technology: gf180mcuD

.subckt opamp_extracted VDD VSS ADJ MINUS PLUS OUT
X0 OUT ADJ VDD.t15 VDD.t0 pfet_03v3 ad=3.7154p pd=14.81u as=3.7154p ps=14.81u w=14.29u l=0.3u
X1 OUT ADJ VDD.t19 VDD.t2 pfet_03v3 ad=3.7154p pd=14.81u as=3.7154p ps=14.81u w=14.29u l=0.3u
X2 VDD.t15 ADJ OUT VDD.t0 pfet_03v3 ad=3.7154p pd=14.81u as=3.7154p ps=14.81u w=14.29u l=0.3u
X3 OUT a_7217_1154# VSS.t11 VSS.t0 nfet_03v3 ad=3.7154p pd=14.81u as=3.7154p ps=14.81u w=14.29u l=0.3u
X4 ADJ ADJ VDD.t6 VDD.t5 pfet_03v3 ad=4.4p pd=20.88u as=4.4p ps=20.88u w=10u l=0.6u
X5 VSS.t2 a_7217_1154# OUT VSS.t2 nfet_03v3 ad=6.2876p pd=29.46u as=3.7154p ps=14.81u w=14.29u l=0.3u
X6 VDD.t8 ADJ OUT VDD.t7 pfet_03v3 ad=3.7154p pd=14.81u as=3.7154p ps=14.81u w=14.29u l=0.3u
X7 VSS.t13 a_7217_1154# OUT VSS.t3 nfet_03v3 ad=3.7154p pd=14.81u as=3.7154p ps=14.81u w=14.29u l=0.3u
X8 OUT ADJ VDD.t8 VDD.t7 pfet_03v3 ad=6.2876p pd=29.46u as=3.7154p ps=14.81u w=14.29u l=0.3u
X9 OUT a_7217_1154# VSS.t19 VSS.t3 nfet_03v3 ad=3.7154p pd=14.81u as=3.7154p ps=14.81u w=14.29u l=0.3u
X10 VDD.t18 ADJ OUT VDD.t7 pfet_03v3 ad=3.7154p pd=14.81u as=3.7154p ps=14.81u w=14.29u l=0.3u
X11 OUT ADJ VDD.t3 VDD.t2 pfet_03v3 ad=3.7154p pd=14.81u as=3.7154p ps=14.81u w=14.29u l=0.3u
X12 OUT ADJ VDD.t24 VDD.t7 pfet_03v3 ad=3.7154p pd=14.81u as=6.2876p ps=29.46u w=14.29u l=0.3u
X13 VDD.t3 ADJ OUT VDD.t2 pfet_03v3 ad=3.7154p pd=14.81u as=3.7154p ps=14.81u w=14.29u l=0.3u
X14 OUT a_7217_1154# VSS.t5 VSS.t0 nfet_03v3 ad=3.7154p pd=14.81u as=3.7154p ps=14.81u w=14.29u l=0.3u
X15 VSS.t5 a_7217_1154# OUT VSS.t0 nfet_03v3 ad=3.7154p pd=14.81u as=3.7154p ps=14.81u w=14.29u l=0.3u
X16 VSS.t17 a_7217_1154# OUT VSS.t0 nfet_03v3 ad=3.7154p pd=14.81u as=6.2876p ps=29.46u w=14.29u l=0.3u
X17 VSS.t12 a_7217_1154# OUT VSS.t2 nfet_03v3 ad=3.7154p pd=14.81u as=3.7154p ps=14.81u w=14.29u l=0.3u
X18 OUT a_7217_1154# VSS.t18 VSS.t2 nfet_03v3 ad=3.7154p pd=14.81u as=3.7154p ps=14.81u w=14.29u l=0.3u
X19 OUT ADJ VDD.t18 VDD.t7 pfet_03v3 ad=3.7154p pd=14.81u as=3.7154p ps=14.81u w=14.29u l=0.3u
X20 OUT a_7217_1154# VSS.t13 VSS.t3 nfet_03v3 ad=3.7154p pd=14.81u as=3.7154p ps=14.81u w=14.29u l=0.3u
X21 a_6465_462# MINUS a_5385_3406# VDD.t27 pfet_03v3 ad=4.4p pd=20.88u as=4.4p ps=20.88u w=10u l=0.6u
X22 VDD.t1 ADJ OUT VDD.t0 pfet_03v3 ad=3.7154p pd=14.81u as=3.7154p ps=14.81u w=14.29u l=0.3u
X23 VSS.t1 a_7217_1154# OUT VSS.t0 nfet_03v3 ad=6.2876p pd=29.46u as=3.7154p ps=14.81u w=14.29u l=0.3u
X24 OUT ADJ VDD.t1 VDD.t0 pfet_03v3 ad=6.2876p pd=29.46u as=3.7154p ps=14.81u w=14.29u l=0.3u
X25 VDD.t20 ADJ OUT VDD.t0 pfet_03v3 ad=3.7154p pd=14.81u as=3.7154p ps=14.81u w=14.29u l=0.3u
X26 a_7217_1154# PLUS a_5385_3406# VDD.t28 pfet_03v3 ad=4.4p pd=20.88u as=4.4p ps=20.88u w=10u l=0.6u
X27 OUT ADJ VDD.t26 VDD.t0 pfet_03v3 ad=3.7154p pd=14.81u as=6.2876p ps=29.46u w=14.29u l=0.3u
X28 VDD.t6 ADJ a_5385_3406# VDD.t5 pfet_03v3 ad=4.4p pd=20.88u as=4.4p ps=20.88u w=10u l=0.6u
X29 OUT ADJ VDD.t14 VDD.t7 pfet_03v3 ad=3.7154p pd=14.81u as=3.7154p ps=14.81u w=14.29u l=0.3u
X30 OUT a_7217_1154# VSS.t7 VSS.t3 nfet_03v3 ad=3.7154p pd=14.81u as=3.7154p ps=14.81u w=14.29u l=0.3u
X31 VDD.t14 ADJ OUT VDD.t7 pfet_03v3 ad=3.7154p pd=14.81u as=3.7154p ps=14.81u w=14.29u l=0.3u
X32 VSS.t7 a_7217_1154# OUT VSS.t3 nfet_03v3 ad=3.7154p pd=14.81u as=3.7154p ps=14.81u w=14.29u l=0.3u
X33 OUT a_7217_1154# VSS.t12 VSS.t2 nfet_03v3 ad=3.7154p pd=14.81u as=3.7154p ps=14.81u w=14.29u l=0.3u
X34 VSS.t19 a_7217_1154# OUT VSS.t3 nfet_03v3 ad=3.7154p pd=14.81u as=6.2876p ps=29.46u w=14.29u l=0.3u
X35 VDD.t9 ADJ OUT VDD.t2 pfet_03v3 ad=3.7154p pd=14.81u as=3.7154p ps=14.81u w=14.29u l=0.3u
X36 OUT ADJ VDD.t9 VDD.t2 pfet_03v3 ad=6.2876p pd=29.46u as=3.7154p ps=14.81u w=14.29u l=0.3u
X37 VSS.t11 a_7217_1154# OUT VSS.t0 nfet_03v3 ad=3.7154p pd=14.81u as=3.7154p ps=14.81u w=14.29u l=0.3u
X38 OUT ADJ VDD.t20 VDD.t0 pfet_03v3 ad=3.7154p pd=14.81u as=3.7154p ps=14.81u w=14.29u l=0.3u
X39 VDD.t19 ADJ OUT VDD.t2 pfet_03v3 ad=3.7154p pd=14.81u as=3.7154p ps=14.81u w=14.29u l=0.3u
X40 OUT a_7217_1154# VSS.t17 VSS.t0 nfet_03v3 ad=3.7154p pd=14.81u as=3.7154p ps=14.81u w=14.29u l=0.3u
X41 a_6465_462# a_6465_462# VSS.t25 VSS.t24 nfet_03v3 ad=3.08p pd=14.88u as=3.08p ps=14.88u w=7u l=0.6u
X42 OUT ADJ VDD.t2 VDD.t2 pfet_03v3 ad=3.7154p pd=14.81u as=6.2876p ps=29.46u w=14.29u l=0.3u
X43 a_7217_1154# a_6465_462# VSS VSS.t23 nfet_03v3 ad=3.08p pd=14.88u as=3.08p ps=14.88u w=7u l=0.6u
X44 OUT a_7217_1154# VSS.t6 VSS.t2 nfet_03v3 ad=3.7154p pd=14.81u as=3.7154p ps=14.81u w=14.29u l=0.3u
X45 VSS.t4 a_7217_1154# OUT VSS.t3 nfet_03v3 ad=6.2876p pd=29.46u as=3.7154p ps=14.81u w=14.29u l=0.3u
X46 VSS.t6 a_7217_1154# OUT VSS.t2 nfet_03v3 ad=3.7154p pd=14.81u as=3.7154p ps=14.81u w=14.29u l=0.3u
X47 VSS.t18 a_7217_1154# OUT VSS.t2 nfet_03v3 ad=3.7154p pd=14.81u as=6.2876p ps=29.46u w=14.29u l=0.3u
R0 VDD.t2 VDD.t7 2001.3
R1 VDD.t2 VDD.t0 2001.3
R2 VDD.t7 VDD.n5 1429.4
R3 VDD.t2 VDD.n9 408.538
R4 VDD.t2 VDD.n15 405.389
R5 VDD.n3 VDD.n5 2.18543
R6 VDD.n6 VDD.t27 129.607
R7 VDD.n8 VDD.t28 129.607
R8 VDD.t27 VDD.n5 129.333
R9 VDD.t28 VDD.n5 129.333
R10 VDD.n14 VDD.n6 121.894
R11 VDD.n8 VDD.n14 121.894
R12 VDD.t6 VDD.n10 100.626
R13 VDD.t5 VDD.n9 100.626
R14 VDD.n14 VDD.n5 97.4755
R15 VDD.n5 VDD.n12 97.4755
R16 VDD.t5 VDD.n6 2.37276
R17 VDD.n15 VDD.n8 61.5095
R18 VDD.n12 VDD.t5 45.5928
R19 VDD.n12 VDD.n11 40.6005
R20 VDD.n11 VDD.n10 38.5845
R21 VDD.n10 VDD.n9 37.4505
R22 VDD.n15 VDD.n11 13.3565
R23 VDD.n13 VDD.n8 3.18376
R24 VDD.n13 VDD.n6 3.18376
R25 VDD.n5 VDD.n13 2.75333
R26 VDD VDD.t5 2.2505
R27 VDD.t5 VDD.n4 0.701517
R28 VDD.n3 VDD.t24 0.940582
R29 VDD.t8 VDD.t24 2.19112
R30 VDD.n2 VDD.t8 2.19112
R31 VDD.t9 VDD.n2 2.19112
R32 VDD.t2 VDD.t9 2.19112
R33 VDD.t1 VDD.n0 0.939314
R34 VDD.t26 VDD.n0 0.314995
R35 VDD.n7 VDD.t18 0.901978
R36 VDD.t14 VDD.t24 2.15858
R37 VDD.n2 VDD.t14 2.15858
R38 VDD.n1 VDD.t19 0.806761
R39 VDD.n1 VDD.t2 0.547556
R40 VDD.t3 VDD.n2 2.15858
R41 VDD.t2 VDD.t3 2.15858
R42 VDD.t20 VDD.t26 0.843971
R43 VDD.t26 VDD.t15 0.896589
R44 VDD.t5 VDD.n3 1.79097
R45 VDD.t24 VDD.n8 1.66321
R46 VDD.n2 VDD.n1 0.547556
R47 VDD.n4 VDD.t6 0.277552
R48 VDD.t6 VDD.t24 0.900657
R49 VDD.n4 VDD.t2 9.57457
R50 VDD VDD.t6 1.31381
R51 VDD.n7 VDD.n2 1.26675
R52 VDD.n7 VDD.t24 1.16396
R53 VDD.n0 VDD.t2 1.38363
R54 VSS.t0 VSS.t2 3850.65
R55 VSS.t2 VSS.t3 3850.65
R56 VSS.n8 VSS.t23 1143.98
R57 VSS.t23 VSS.t0 908.456
R58 VSS.t24 VSS.t25 725.771
R59 VSS.n2 VSS.n8 647.423
R60 VSS.n5 VSS.n2 14.1409
R61 VSS.n5 VSS.t25 71.6614
R62 VSS.t2 VSS.n5 246.915
R63 VSS.n8 VSS.t24 78.3487
R64 VSS.n7 VSS 11.9783
R65 VSS.t4 VSS.n7 9.20285
R66 VSS.n6 VSS 5.69473
R67 VSS.n6 VSS 3.94755
R68 VSS.t2 VSS.n6 2.45127
R69 VSS.n7 VSS.t2 2.45127
R70 VSS VSS.n3 2.28547
R71 VSS.n3 VSS.t17 2.19112
R72 VSS.t17 VSS.t1 2.19112
R73 VSS.t18 VSS.n1 0.805329
R74 VSS.t2 VSS.n1 0.582966
R75 VSS.t19 VSS.t2 2.19112
R76 VSS.t4 VSS.t19 2.19112
R77 VSS.n3 VSS.t11 2.15858
R78 VSS.t11 VSS.t1 2.15858
R79 VSS.n0 VSS.n3 0.480435
R80 VSS.n0 VSS.t5 0.840321
R81 VSS.t12 VSS.t1 2.15858
R82 VSS.t2 VSS.t12 2.15858
R83 VSS.t1 VSS.t6 2.15858
R84 VSS.t6 VSS.t2 2.15858
R85 VSS.t13 VSS.t2 2.15858
R86 VSS.t4 VSS.t13 2.15858
R87 VSS.n1 VSS.t1 0.582966
R88 VSS VSS.n2 1.56202
R89 VSS.t2 VSS.n4 1.4092
R90 VSS.t1 VSS.n0 1.40803
R91 VSS.t7 VSS.n4 0.840697
R92 VSS.t4 VSS.n4 0.479683
R93 VSS VSS.t25 1.14246
C0 ADJ MINUS 0.00126f
C1 a_5385_3406# a_6465_462# 0.9011f
C2 ADJ VDD 23.8369f
C3 OUT a_7217_1154# 5.64399f
C4 PLUS a_5385_3406# 2.4824f
C5 ADJ a_6465_462# 0
C6 PLUS ADJ 0.00222f
C7 OUT VDD 45.7688f
C8 OUT a_6465_462# 0.00188f
C9 PLUS OUT 0
C10 a_5385_3406# ADJ 2.45499f
C11 MINUS a_7217_1154# 0
C12 VDD a_7217_1154# 2.31948f
C13 a_5385_3406# OUT 0
C14 VDD MINUS 0.62716f
C15 a_6465_462# a_7217_1154# 1.81292f
C16 PLUS a_7217_1154# 2.43165f
C17 ADJ OUT 6.32333f
C18 MINUS a_6465_462# 2.45769f
C19 PLUS MINUS 0.14213f
C20 VDD a_6465_462# 2.25994f
C21 PLUS VDD 0.75114f
C22 PLUS a_6465_462# 0.23248f
C23 a_5385_3406# a_7217_1154# 0.4474f
C24 a_5385_3406# MINUS 2.48532f
C25 ADJ a_7217_1154# 0.02957f
C26 a_5385_3406# VDD 6.42547f
C27 PLUS VSS 0.21006f
C28 MINUS VSS 0.03948f
C29 OUT VSS 41.6154f
C30 ADJ VSS 1.97339f
C31 VDD VSS 73.70123f
C32 a_7217_1154# VSS 19.3591f
C33 a_6465_462# VSS 5.92443f
C34 a_5385_3406# VSS 0.59206f
C35 VDD.t26 VSS 3.73289f
C36 VDD.n0 VSS 2.91842f
C37 VDD.n2 VSS 7.07602f
C38 VDD.n3 VSS 0.10282f
C39 VDD.t5 VSS 4.73493f
C40 VDD.n4 VSS 0.29463f
C41 VDD.t24 VSS 3.64166f
C42 VDD.t2 VSS 18.2476f
C43 VDD.t6 VSS 2.53744f
C44 VDD.n5 VSS 5.8259f
C45 VDD.n6 VSS 1.10468f
C46 VDD.n8 VSS 1.05296f
C47 VDD.n9 VSS 0.48132f
C48 VDD.n10 VSS 0.1613f
C49 VDD.t8 VSS 0.80787f
C50 VDD.t14 VSS 0.79108f
C51 VDD.t9 VSS 0.81388f
C52 VDD.t3 VSS 0.79108f
C53 VDD.t1 VSS 0.80862f
C54 VDD.t15 VSS 0.79106f
C55 VDD.t0 VSS 10.5216f
C56 VDD.t7 VSS 8.75201f
C57 VDD.n11 VSS 0.17369f
C58 VDD.t27 VSS 1.03588f
C59 VDD.n12 VSS 0.1652f
C60 VDD.n13 VSS 0.03987f
C61 VDD.n14 VSS 0.48744f
C62 VDD.t28 VSS 1.03588f
C63 VDD.n15 VSS 0.51516f
C64 VDD.t20 VSS 0.79106f
C65 VDD.t19 VSS 0.79108f
C66 VDD.t18 VSS 0.79108f
.ends
