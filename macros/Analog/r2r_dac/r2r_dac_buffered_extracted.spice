* NGSPICE file created from r2r_dac_buffered_extracted.ext - technology: gf180mcuD

.subckt r2r_dac_buffered_extracted VDD VSS D0 D1 D2 D3 D4 D5 D6 D7 D8 D9 D10 D11 OUT
X0 D3 a_13098_5067# VSS.t11 ppolyf_u_1k r_width=1u r_length=8u
X1 OUT x1.ADJ VDD.t8 VDD.t7 pfet_03v3 ad=6.2876p pd=29.46u as=3.7154p ps=14.81u w=14.29u l=0.3u
X2 x1.MINUS OUT VSS.t49 ppolyf_u_1k r_width=1u r_length=22.5u
X3 a_6294_5067# a_7266_5067# VSS.t6 ppolyf_u_1k r_width=1u r_length=4u
X4 x1.ADJ x1.ADJ VDD.t3 VDD.t3 pfet_03v3 ad=4.4p pd=20.88u as=4.4p ps=20.88u w=10u l=0.6u
X5 VDD.t16 x1.ADJ OUT VDD.t9 pfet_03v3 ad=3.7154p pd=14.81u as=3.7154p ps=14.81u w=14.29u l=0.3u
X6 VSS.t41 x1.ADJ VSS.t56 ppolyf_u_1k r_width=1u r_length=30u
X7 OUT x1.ADJ VDD.t22 VDD.t9 pfet_03v3 ad=3.7154p pd=14.81u as=3.7154p ps=14.81u w=14.29u l=0.3u
X8 D0 a_15685_799# VSS.t12 ppolyf_u_1k r_width=1u r_length=8u
X9 a_12126_5067# a_13098_5067# VSS.t52 ppolyf_u_1k r_width=1u r_length=4u
X10 VDD.t22 x1.ADJ OUT VDD.t9 pfet_03v3 ad=3.7154p pd=14.81u as=3.7154p ps=14.81u w=14.29u l=0.3u
X11 VDD.t6 x1.ADJ OUT VDD.t5 pfet_03v3 ad=3.7154p pd=14.81u as=3.7154p ps=14.81u w=14.29u l=0.3u
X12 VSS.t21 a_6673_1001# OUT VSS.t20 nfet_03v3 ad=6.2876p pd=29.46u as=3.7154p ps=14.81u w=14.29u l=0.3u
X13 D5 a_11154_5067# VSS.t14 ppolyf_u_1k r_width=1u r_length=8u
X14 a_9210_5067# a_10182_5067# VSS.t43 ppolyf_u_1k r_width=1u r_length=4u
X15 OUT x1.ADJ VDD.t14 VDD.t5 pfet_03v3 ad=3.7154p pd=14.81u as=3.7154p ps=14.81u w=14.29u l=0.3u
X16 OUT x1.ADJ VDD.t3 VDD.t5 pfet_03v3 ad=3.7154p pd=14.81u as=6.2876p ps=29.46u w=14.29u l=0.3u
X17 OUT a_6673_1001# VSS.t24 VSS.t20 nfet_03v3 ad=3.7154p pd=14.81u as=3.7154p ps=14.81u w=14.29u l=0.3u
X18 VSS.t23 a_6673_1001# OUT VSS.t19 nfet_03v3 ad=3.7154p pd=14.81u as=3.7154p ps=14.81u w=14.29u l=0.3u
X19 OUT a_6673_1001# VSS.t36 VSS.t20 nfet_03v3 ad=3.7154p pd=14.81u as=3.7154p ps=14.81u w=14.29u l=0.3u
X20 a_5921_309# a_5921_309# VSS.t41 VSS.t42 nfet_03v3 ad=3.08p pd=14.88u as=3.08p ps=14.88u w=7u l=0.6u
X21 VSS.t36 a_6673_1001# OUT VSS.t20 nfet_03v3 ad=3.7154p pd=14.81u as=6.2876p ps=29.46u w=14.29u l=0.3u
X22 VDD.t15 x1.ADJ OUT VDD.t7 pfet_03v3 ad=3.7154p pd=14.81u as=3.7154p ps=14.81u w=14.29u l=0.3u
X23 VDD.t1 a_3265_798# VSS.t10 ppolyf_u_1k r_width=1u r_length=10u
X24 OUT a_6673_1001# VSS.t28 VSS.t17 nfet_03v3 ad=3.7154p pd=14.81u as=3.7154p ps=14.81u w=14.29u l=0.3u
X25 OUT x1.ADJ VDD.t21 VDD.t7 pfet_03v3 ad=3.7154p pd=14.81u as=3.7154p ps=14.81u w=14.29u l=0.3u
X26 VSS.t28 a_6673_1001# OUT VSS.t17 nfet_03v3 ad=3.7154p pd=14.81u as=3.7154p ps=14.81u w=14.29u l=0.3u
X27 a_7266_5067# a_8238_5067# VSS.t5 ppolyf_u_1k r_width=1u r_length=4u
X28 a_3265_798# x1.PLUS VSS.t7 ppolyf_u_1k r_width=1u r_length=10u
X29 VDD.t21 x1.ADJ OUT VDD.t7 pfet_03v3 ad=3.7154p pd=14.81u as=3.7154p ps=14.81u w=14.29u l=0.3u
X30 D10 a_6294_5067# VSS.t16 ppolyf_u_1k r_width=1u r_length=8u
X31 VSS.t19 a_6673_1001# OUT VSS.t19 nfet_03v3 ad=6.2876p pd=29.46u as=3.7154p ps=14.81u w=14.29u l=0.3u
X32 OUT a_6673_1001# VSS.t23 VSS.t19 nfet_03v3 ad=3.7154p pd=14.81u as=3.7154p ps=14.81u w=14.29u l=0.3u
X33 OUT a_6673_1001# VSS.t35 VSS.t19 nfet_03v3 ad=3.7154p pd=14.81u as=3.7154p ps=14.81u w=14.29u l=0.3u
X34 OUT x1.ADJ VDD.t6 VDD.t5 pfet_03v3 ad=6.2876p pd=29.46u as=3.7154p ps=14.81u w=14.29u l=0.3u
X35 VSS.t35 a_6673_1001# OUT VSS.t19 nfet_03v3 ad=3.7154p pd=14.81u as=6.2876p ps=29.46u w=14.29u l=0.3u
X36 D4 a_12126_5067# VSS.t53 ppolyf_u_1k r_width=1u r_length=8u
X37 a_1315_2647# a_6294_5067# VSS.t9 ppolyf_u_1k r_width=1u r_length=4u
X38 a_1315_2647# x1.MINUS VSS.t13 ppolyf_u_1k r_width=1u r_length=20u
X39 D7 a_9210_5067# VSS.t46 ppolyf_u_1k r_width=1u r_length=8u
X40 a_15042_5067# a_15685_799# VSS.t2 ppolyf_u_1k r_width=1u r_length=4u
X41 VDD.t10 x1.ADJ OUT VDD.t9 pfet_03v3 ad=3.7154p pd=14.81u as=3.7154p ps=14.81u w=14.29u l=0.3u
X42 VSS.t48 a_15685_799# VSS.t47 ppolyf_u_1k r_width=1u r_length=8u
X43 a_10182_5067# a_11154_5067# VSS.t55 ppolyf_u_1k r_width=1u r_length=4u
X44 OUT x1.ADJ VDD.t16 VDD.t9 pfet_03v3 ad=3.7154p pd=14.81u as=3.7154p ps=14.81u w=14.29u l=0.3u
X45 OUT x1.ADJ VDD VDD.t9 pfet_03v3 ad=3.7154p pd=14.81u as=6.2876p ps=29.46u w=14.29u l=0.3u
X46 D2 a_14070_5067# VSS.t4 ppolyf_u_1k r_width=1u r_length=8u
X47 a_6673_1001# x1.PLUS a_4841_3253# VDD.t0 pfet_03v3 ad=4.4p pd=20.88u as=4.4p ps=20.88u w=10u l=0.6u
X48 VSS.t22 a_6673_1001# OUT VSS.t17 nfet_03v3 ad=3.7154p pd=14.81u as=3.7154p ps=14.81u w=14.29u l=0.3u
X49 a_8238_5067# a_9210_5067# VSS.t44 ppolyf_u_1k r_width=1u r_length=4u
X50 VDD.t3 x1.ADJ a_4841_3253# VDD.t3 pfet_03v3 ad=4.4p pd=20.88u as=4.4p ps=20.88u w=10u l=0.6u
X51 OUT a_6673_1001# VSS.t30 VSS.t20 nfet_03v3 ad=3.7154p pd=14.81u as=3.7154p ps=14.81u w=14.29u l=0.3u
X52 D9 a_7266_5067# VSS.t45 ppolyf_u_1k r_width=1u r_length=8u
X53 a_13098_5067# a_14070_5067# VSS.t51 ppolyf_u_1k r_width=1u r_length=4u
X54 VDD.t14 x1.ADJ OUT VDD.t5 pfet_03v3 ad=3.7154p pd=14.81u as=3.7154p ps=14.81u w=14.29u l=0.3u
X55 VSS.t30 a_6673_1001# OUT VSS.t20 nfet_03v3 ad=3.7154p pd=14.81u as=3.7154p ps=14.81u w=14.29u l=0.3u
X56 VSS.t15 a_3265_246# VSS.t10 ppolyf_u_1k r_width=1u r_length=10u
X57 OUT x1.ADJ VDD.t20 VDD.t5 pfet_03v3 ad=3.7154p pd=14.81u as=3.7154p ps=14.81u w=14.29u l=0.3u
X58 a_3265_246# x1.PLUS VSS.t7 ppolyf_u_1k r_width=1u r_length=10u
X59 VDD.t8 x1.ADJ OUT VDD.t7 pfet_03v3 ad=3.7154p pd=14.81u as=3.7154p ps=14.81u w=14.29u l=0.3u
X60 VDD.t20 x1.ADJ OUT VDD.t5 pfet_03v3 ad=3.7154p pd=14.81u as=3.7154p ps=14.81u w=14.29u l=0.3u
X61 OUT x1.ADJ VDD.t15 VDD.t7 pfet_03v3 ad=3.7154p pd=14.81u as=3.7154p ps=14.81u w=14.29u l=0.3u
X62 a_5921_309# x1.MINUS a_4841_3253# VDD.t2 pfet_03v3 ad=4.4p pd=20.88u as=4.4p ps=20.88u w=10u l=0.6u
X63 OUT x1.ADJ VDD.t7 VDD.t7 pfet_03v3 ad=3.7154p pd=14.81u as=6.2876p ps=29.46u w=14.29u l=0.3u
X64 VSS.t18 a_6673_1001# OUT VSS.t17 nfet_03v3 ad=6.2876p pd=29.46u as=3.7154p ps=14.81u w=14.29u l=0.3u
X65 a_6673_1001# a_5921_309# VSS.t41 VSS.t40 nfet_03v3 ad=3.08p pd=14.88u as=3.08p ps=14.88u w=7u l=0.6u
X66 OUT x1.ADJ VDD.t10 VDD.t9 pfet_03v3 ad=6.2876p pd=29.46u as=3.7154p ps=14.81u w=14.29u l=0.3u
X67 OUT a_6673_1001# VSS.t22 VSS.t17 nfet_03v3 ad=3.7154p pd=14.81u as=3.7154p ps=14.81u w=14.29u l=0.3u
X68 OUT a_6673_1001# VSS.t34 VSS.t17 nfet_03v3 ad=3.7154p pd=14.81u as=3.7154p ps=14.81u w=14.29u l=0.3u
X69 D11 a_1315_2647# VSS.t8 ppolyf_u_1k r_width=1u r_length=8u
X70 a_11154_5067# a_12126_5067# VSS.t54 ppolyf_u_1k r_width=1u r_length=4u
X71 VSS.t34 a_6673_1001# OUT VSS.t17 nfet_03v3 ad=3.7154p pd=14.81u as=6.2876p ps=29.46u w=14.29u l=0.3u
X72 D6 a_10182_5067# VSS.t0 ppolyf_u_1k r_width=1u r_length=8u
X73 D1 a_15042_5067# VSS.t1 ppolyf_u_1k r_width=1u r_length=8u
X74 OUT a_6673_1001# VSS.t29 VSS.t19 nfet_03v3 ad=3.7154p pd=14.81u as=3.7154p ps=14.81u w=14.29u l=0.3u
X75 VSS.t29 a_6673_1001# OUT VSS.t19 nfet_03v3 ad=3.7154p pd=14.81u as=3.7154p ps=14.81u w=14.29u l=0.3u
X76 D8 a_8238_5067# VSS.t50 ppolyf_u_1k r_width=1u r_length=8u
X77 a_14070_5067# a_15042_5067# VSS.t3 ppolyf_u_1k r_width=1u r_length=4u
X78 VSS.t24 a_6673_1001# OUT VSS.t20 nfet_03v3 ad=3.7154p pd=14.81u as=3.7154p ps=14.81u w=14.29u l=0.3u
R0 VDD.t7 VDD.t5 1916.87
R1 VDD.t7 VDD.t9 1916.87
R2 VDD.t5 VDD.n5 1371.59
R3 VDD.n14 VDD.n0 92.4629
R4 VDD.t7 VDD.n12 405.389
R5 VDD.t3 VDD.n3 2.1734
R6 VDD.n11 VDD.t2 129.607
R7 VDD.n13 VDD.t0 129.607
R8 VDD.t0 VDD.n6 129.333
R9 VDD.t2 VDD.n5 127.263
R10 VDD.n11 VDD.n10 121.894
R11 VDD.n13 VDD.n10 121.894
R12 VDD.t3 VDD.n0 0.662448
R13 VDD.n11 VDD.t3 1.6582
R14 VDD.n6 VDD.n10 97.4755
R15 VDD.n6 VDD.n7 97.4755
R16 VDD.n13 VDD.n12 61.5095
R17 VDD.t3 VDD.n7 45.6066
R18 VDD.n7 VDD.n14 40.6005
R19 VDD.n14 VDD.n12 13.3565
R20 VDD.n13 VDD.n9 3.18376
R21 VDD.n3 VDD.n5 2.57946
R22 VDD.n6 VDD.n9 2.2055
R23 VDD.n6 VDD.n3 0.0186931
R24 VDD.t10 VDD.t7 2.19112
R25 VDD VDD.t10 2.19112
R26 VDD.t8 VDD.n4 0.822002
R27 VDD.t7 VDD.n4 0.54962
R28 VDD.t3 VDD.t6 2.19112
R29 VDD.t6 VDD.n2 2.19112
R30 VDD.t22 VDD 2.15858
R31 VDD.n1 VDD.t16 0.880743
R32 VDD.n2 VDD.t21 2.15858
R33 VDD.t21 VDD.t7 2.15858
R34 VDD.t15 VDD.n2 2.15858
R35 VDD.t7 VDD.t15 2.15858
R36 VDD.t20 VDD.n8 0.901978
R37 VDD.t3 VDD.t14 2.15858
R38 VDD.t14 VDD.n2 2.15858
R39 VDD.t7 VDD.t22 2.15685
R40 VDD VDD.n1 0.398885
R41 VDD.t1 VDD.n9 1.7114
R42 VDD.t3 VDD.n13 1.66321
R43 VDD VDD.t3 1.76934
R44 VDD.n4 VDD.n2 0.54962
R45 VDD.n11 VDD.t1 1.34068
R46 VDD.n8 VDD.t3 1.16707
R47 VDD.t7 VDD.n0 3.55899
R48 VDD.n2 VDD.n8 1.26675
R49 VDD.n1 VDD.t7 1.16757
R50 VSS.n6 VSS.t47 6766.82
R51 VSS.t20 VSS.t19 3765.47
R52 VSS.n134 VSS.n28 3277.92
R53 VSS.t17 VSS.t56 2791.81
R54 VSS.n134 VSS.t40 1118.67
R55 VSS.t40 VSS.t17 888.359
R56 VSS.n1 VSS.t42 720.626
R57 VSS.n134 VSS.t41 714.865
R58 VSS.n67 VSS.n70 134.702
R59 VSS.t19 VSS.t49 513.03
R60 VSS.n29 VSS.n28 508.276
R61 VSS.t10 VSS.t13 503.038
R62 VSS.t56 VSS.t49 460.63
R63 VSS.t7 VSS.t13 429.214
R64 VSS.n4 VSS.t56 1.58833
R65 VSS.n67 VSS.t19 162.581
R66 VSS.n26 VSS.t8 272.397
R67 VSS.t16 VSS.n25 272.397
R68 VSS.n24 VSS.t16 272.397
R69 VSS.t45 VSS.n23 272.397
R70 VSS.n22 VSS.t45 272.397
R71 VSS.t50 VSS.n21 272.397
R72 VSS.n20 VSS.t50 272.397
R73 VSS.t46 VSS.n19 272.397
R74 VSS.n18 VSS.t46 272.397
R75 VSS.t0 VSS.n17 272.397
R76 VSS.n16 VSS.t0 272.397
R77 VSS.t14 VSS.n15 272.397
R78 VSS.n14 VSS.t14 272.397
R79 VSS.t53 VSS.n13 272.397
R80 VSS.n12 VSS.t53 272.397
R81 VSS.t11 VSS.n11 272.397
R82 VSS.n10 VSS.t11 272.397
R83 VSS.t4 VSS.n62 272.397
R84 VSS.n8 VSS.t4 272.397
R85 VSS.n64 VSS.t1 92.1791
R86 VSS.n63 VSS.n64 88.0408
R87 VSS.n7 VSS.t12 135.96
R88 VSS.n7 VSS.n6 0.479386
R89 VSS.n26 VSS.n29 2.55886
R90 VSS.n64 VSS.n27 88.0408
R91 VSS.t8 VSS.n111 238.84
R92 VSS.t56 VSS.n72 209.505
R93 VSS.n25 VSS.t9 204.298
R94 VSS.n23 VSS.t6 204.298
R95 VSS.n21 VSS.t5 204.298
R96 VSS.n19 VSS.t44 204.298
R97 VSS.n17 VSS.t43 204.298
R98 VSS.n15 VSS.t55 204.298
R99 VSS.n13 VSS.t54 204.298
R100 VSS.n11 VSS.t52 204.298
R101 VSS.n62 VSS.t51 204.298
R102 VSS.t3 VSS.n27 204.298
R103 VSS.n39 VSS.n69 174.222
R104 VSS.n42 VSS.n37 166.945
R105 VSS.t47 VSS.t20 164.512
R106 VSS.n26 VSS.n43 145.081
R107 VSS.n24 VSS.n45 145.081
R108 VSS.n22 VSS.n47 145.081
R109 VSS.n20 VSS.n49 145.081
R110 VSS.n18 VSS.n51 145.081
R111 VSS.n16 VSS.n53 145.081
R112 VSS.n14 VSS.n55 145.081
R113 VSS.n12 VSS.n57 145.081
R114 VSS.n10 VSS.n59 145.081
R115 VSS.n8 VSS.n80 145.081
R116 VSS.n132 VSS.n63 145.081
R117 VSS.n9 VSS.t2 144.095
R118 VSS.n69 VSS.n40 124.834
R119 VSS.n133 VSS.n65 120.945
R120 VSS.n90 VSS.n29 105.064
R121 VSS.n9 VSS.n66 1.11487
R122 VSS.n26 VSS.n44 1.03587
R123 VSS.n89 VSS.n25 103.251
R124 VSS.n24 VSS.n46 1.03587
R125 VSS.n88 VSS.n23 103.251
R126 VSS.n22 VSS.n48 1.03587
R127 VSS.n87 VSS.n21 103.251
R128 VSS.n20 VSS.n50 1.03587
R129 VSS.n86 VSS.n19 103.251
R130 VSS.n18 VSS.n52 1.03587
R131 VSS.n85 VSS.n17 103.251
R132 VSS.n16 VSS.n54 1.03587
R133 VSS.n84 VSS.n15 103.251
R134 VSS.n14 VSS.n56 1.03587
R135 VSS.n83 VSS.n13 103.251
R136 VSS.n12 VSS.n58 1.03587
R137 VSS.n82 VSS.n11 103.251
R138 VSS.n10 VSS.n60 1.03587
R139 VSS.n81 VSS.n62 103.251
R140 VSS.n61 VSS.n81 70.5428
R141 VSS.n77 VSS.n27 103.251
R142 VSS.n63 VSS.n76 103.251
R143 VSS.n6 VSS.n65 103.251
R144 VSS.n106 VSS.n91 94.5005
R145 VSS.n106 VSS.n105 94.5005
R146 VSS.n105 VSS.n104 94.5005
R147 VSS.n104 VSS.n93 94.5005
R148 VSS.n100 VSS.n93 94.5005
R149 VSS.n100 VSS.n99 94.5005
R150 VSS.n99 VSS.n98 94.5005
R151 VSS.n98 VSS.n95 94.5005
R152 VSS.n95 VSS.n74 94.5005
R153 VSS.n133 VSS.n74 94.5005
R154 VSS.t7 VSS.n28 83.2678
R155 VSS.n1 VSS.n37 74.5217
R156 VSS.t41 VSS.n37 74.0255
R157 VSS.n110 VSS.n91 71.391
R158 VSS.n72 VSS.n71 63.6144
R159 VSS.n113 VSS.n43 62.1778
R160 VSS.n115 VSS.n45 62.1778
R161 VSS.n117 VSS.n47 62.1778
R162 VSS.n119 VSS.n49 62.1778
R163 VSS.n121 VSS.n51 62.1778
R164 VSS.n123 VSS.n53 62.1778
R165 VSS.n125 VSS.n55 62.1778
R166 VSS.n127 VSS.n57 62.1778
R167 VSS.n129 VSS.n59 62.1778
R168 VSS.n80 VSS.n79 62.1778
R169 VSS.n132 VSS.n75 62.1778
R170 VSS.n77 VSS.n76 53.6672
R171 VSS.n66 VSS.n65 66.2344
R172 VSS.t19 VSS.n38 3.69947
R173 VSS.n71 VSS.n4 84.3162
R174 VSS.n67 VSS.n72 87.5157
R175 VSS.n37 VSS.n69 34.5005
R176 VSS.n111 VSS.n29 33.5565
R177 VSS.n71 VSS.n70 31.2817
R178 VSS.n44 VSS.n90 60.5289
R179 VSS.n112 VSS.n89 20.4172
R180 VSS.n46 VSS.n89 70.5428
R181 VSS.n114 VSS.n88 20.4172
R182 VSS.n48 VSS.n88 70.5428
R183 VSS.n116 VSS.n87 20.4172
R184 VSS.n50 VSS.n87 70.5428
R185 VSS.n118 VSS.n86 20.4172
R186 VSS.n52 VSS.n86 70.5428
R187 VSS.n120 VSS.n85 20.4172
R188 VSS.n54 VSS.n85 70.5428
R189 VSS.n122 VSS.n84 20.4172
R190 VSS.n56 VSS.n84 70.5428
R191 VSS.n124 VSS.n83 20.4172
R192 VSS.n58 VSS.n83 70.5428
R193 VSS.n126 VSS.n82 20.4172
R194 VSS.n60 VSS.n82 70.5428
R195 VSS.n128 VSS.n81 20.4172
R196 VSS.n61 VSS.n78 0.205636
R197 VSS.n78 VSS.n77 20.4172
R198 VSS.n130 VSS.n76 20.4172
R199 VSS.n1 VSS.n70 16.2045
R200 VSS.n110 VSS.n90 14.353
R201 VSS.t42 VSS.n134 5.76291
R202 VSS.t56 VSS.n38 5.53361
R203 VSS.t19 VSS.n3 5.48975
R204 VSS.n39 VSS.t10 4.16171
R205 VSS.n4 VSS.t41 0.247539
R206 VSS.n38 VSS.t48 0.0599666
R207 VSS.n131 VSS.n3 3.28159
R208 VSS.n2 VSS.n39 3.05155
R209 VSS.t9 VSS.n113 2.96133
R210 VSS.t6 VSS.n115 2.96133
R211 VSS.t5 VSS.n117 2.96133
R212 VSS.t44 VSS.n119 2.96133
R213 VSS.t43 VSS.n121 2.96133
R214 VSS.t55 VSS.n123 2.96133
R215 VSS.t54 VSS.n125 2.96133
R216 VSS.t52 VSS.n127 2.96133
R217 VSS.t51 VSS.n129 2.96133
R218 VSS.n79 VSS.t3 2.96133
R219 VSS.t2 VSS.n75 2.96133
R220 VSS.n41 VSS.n40 2.67828
R221 VSS.n0 VSS.t10 0.292567
R222 VSS.n32 VSS.n131 2.28547
R223 VSS.n109 VSS.n68 2.20876
R224 VSS.n32 VSS.t34 2.19112
R225 VSS.t34 VSS.t18 2.19112
R226 VSS.t35 VSS.n31 2.19112
R227 VSS.n36 VSS.t35 2.19112
R228 VSS.t36 VSS.n34 2.19112
R229 VSS.t21 VSS.t36 2.19112
R230 VSS.n32 VSS.t28 2.15858
R231 VSS.t28 VSS.t18 2.15858
R232 VSS.n33 VSS.n32 0.480435
R233 VSS.n33 VSS.t22 0.840321
R234 VSS.t29 VSS.n31 2.15858
R235 VSS.n36 VSS.t29 2.15858
R236 VSS.n31 VSS.t23 2.15858
R237 VSS.t23 VSS.n36 2.15858
R238 VSS.t30 VSS.n34 2.15858
R239 VSS.t21 VSS.t30 2.15858
R240 VSS.n34 VSS.n35 0.479713
R241 VSS.t24 VSS.n35 0.840682
R242 VSS.t15 VSS.n41 1.6543
R243 VSS.n2 VSS.n40 1.60593
R244 VSS.n42 VSS.n2 1.47655
R245 VSS.n0 VSS.t15 0.825526
R246 VSS.n30 VSS.n6 1.43786
R247 VSS.n66 VSS.n130 0.157278
R248 VSS.n8 VSS.n61 1.03587
R249 VSS.n128 VSS.n60 0.205636
R250 VSS.n126 VSS.n58 0.205636
R251 VSS.n124 VSS.n56 0.205636
R252 VSS.n122 VSS.n54 0.205636
R253 VSS.n120 VSS.n52 0.205636
R254 VSS.n118 VSS.n50 0.205636
R255 VSS.n116 VSS.n48 0.205636
R256 VSS.n114 VSS.n46 0.205636
R257 VSS.n112 VSS.n44 0.205636
R258 VSS VSS.n135 1.14975
R259 VSS.n108 VSS.n107 1.04193
R260 VSS.n107 VSS.n92 1.04193
R261 VSS.n103 VSS.n92 1.04193
R262 VSS.n103 VSS.n102 1.04193
R263 VSS.n102 VSS.n101 1.04193
R264 VSS.n101 VSS.n94 1.04193
R265 VSS.n97 VSS.n94 1.04193
R266 VSS.n97 VSS.n96 1.04193
R267 VSS.n96 VSS.n73 1.04193
R268 VSS.n5 VSS.n73 1.04193
R269 VSS.n130 VSS.n75 1.0405
R270 VSS.n79 VSS.n78 1.0405
R271 VSS.n129 VSS.n128 1.0405
R272 VSS.n127 VSS.n126 1.0405
R273 VSS.n125 VSS.n124 1.0405
R274 VSS.n123 VSS.n122 1.0405
R275 VSS.n121 VSS.n120 1.0405
R276 VSS.n119 VSS.n118 1.0405
R277 VSS.n117 VSS.n116 1.0405
R278 VSS.n115 VSS.n114 1.0405
R279 VSS.n113 VSS.n112 1.0405
R280 VSS.n109 VSS.n108 0.974335
R281 VSS.t41 VSS.n3 1.10588
R282 VSS.n111 VSS.n110 0.867167
R283 VSS.n110 VSS.n109 0.867167
R284 VSS.n6 VSS.n5 0.858701
R285 VSS.n135 VSS.n68 0.829362
R286 VSS.n131 VSS.n2 0.71
R287 VSS.n135 VSS.t15 0.700824
R288 VSS.n133 VSS.n132 0.578278
R289 VSS.n5 VSS.n133 0.578278
R290 VSS.n80 VSS.n74 0.578278
R291 VSS.n74 VSS.n73 0.578278
R292 VSS.n95 VSS.n59 0.578278
R293 VSS.n96 VSS.n95 0.578278
R294 VSS.n98 VSS.n57 0.578278
R295 VSS.n98 VSS.n97 0.578278
R296 VSS.n99 VSS.n55 0.578278
R297 VSS.n99 VSS.n94 0.578278
R298 VSS.n100 VSS.n53 0.578278
R299 VSS.n101 VSS.n100 0.578278
R300 VSS.n93 VSS.n51 0.578278
R301 VSS.n102 VSS.n93 0.578278
R302 VSS.n104 VSS.n49 0.578278
R303 VSS.n104 VSS.n103 0.578278
R304 VSS.n105 VSS.n47 0.578278
R305 VSS.n105 VSS.n92 0.578278
R306 VSS.n106 VSS.n45 0.578278
R307 VSS.n107 VSS.n106 0.578278
R308 VSS.n91 VSS.n43 0.578278
R309 VSS.n108 VSS.n91 0.578278
R310 VSS.t15 VSS.t13 0.520467
R311 VSS.t56 VSS.n30 3.54197
R312 VSS.n10 VSS.n62 1.15837
R313 VSS.n2 VSS.n1 1.06606
R314 VSS.t10 VSS.n41 1.0342
R315 VSS.n68 VSS.n29 0.965102
R316 VSS.n9 VSS.n7 0.479386
R317 VSS.t18 VSS.n33 0.480435
R318 VSS.n35 VSS.t21 0.479713
R319 VSS.n36 VSS.n34 0.930021
R320 VSS.n31 VSS.t18 0.928095
R321 VSS.n9 VSS.n8 0.907804
R322 VSS.n24 VSS.n26 0.899141
R323 VSS.n22 VSS.n24 0.899141
R324 VSS.n20 VSS.n22 0.899141
R325 VSS.n18 VSS.n20 0.899141
R326 VSS.n16 VSS.n18 0.899141
R327 VSS.n14 VSS.n16 0.899141
R328 VSS.n12 VSS.n14 0.899141
R329 VSS.n10 VSS.n12 0.899141
R330 VSS.n8 VSS.n10 0.897524
R331 VSS.t19 VSS.n31 0.793739
R332 VSS.n2 VSS.t41 0.741087
R333 VSS.n63 VSS.n9 0.709591
R334 VSS.n30 VSS.t21 0.707358
R335 VSS.n8 VSS.n27 0.686446
R336 VSS.n26 VSS.n25 0.684028
R337 VSS.n24 VSS.n23 0.684028
R338 VSS.n22 VSS.n21 0.684028
R339 VSS.n20 VSS.n19 0.684028
R340 VSS.n18 VSS.n17 0.684028
R341 VSS.n16 VSS.n15 0.684028
R342 VSS.n14 VSS.n13 0.684028
R343 VSS.n12 VSS.n11 0.684028
R344 VSS.n30 VSS.t48 0.652218
R345 VSS.t19 VSS.n36 0.651324
R346 VSS.t7 VSS.n42 0.5205
R347 VSS.t7 VSS.n40 0.5205
R348 VSS.n39 VSS.t7 0.5205
R349 VSS.n42 VSS.n0 2.49465
C0 D3 D4 0.04253f
C1 a_6294_5067# a_7266_5067# 0.02034f
C2 a_1315_2647# x1.ADJ 0.19722f
C3 VDD a_9210_5067# 0.01298f
C4 D5 D4 0.04253f
C5 VDD D0 0.02058f
C6 D10 D9 0.04253f
C7 D10 D11 0.04253f
C8 x1.ADJ a_15685_799# 0.20073f
C9 OUT a_15685_799# 0.2573f
C10 a_8238_5067# a_9210_5067# 0.02034f
C11 a_10182_5067# a_9210_5067# 0.02034f
C12 a_3265_798# a_3265_246# 0.00558f
C13 x1.ADJ a_7266_5067# 0.00908f
C14 OUT a_7266_5067# 0
C15 a_6673_1001# VDD 2.32633f
C16 VDD a_8238_5067# 0.0113f
C17 VDD x1.MINUS 0.93797f
C18 VDD a_10182_5067# 0.01179f
C19 a_6673_1001# x1.MINUS 0.30984f
C20 a_13098_5067# a_12126_5067# 0.02034f
C21 a_1315_2647# VDD 1.40096f
C22 a_11154_5067# a_12126_5067# 0.02034f
C23 a_14070_5067# a_15042_5067# 0.02034f
C24 a_13098_5067# a_14070_5067# 0.02034f
C25 x1.ADJ a_15042_5067# 0.00908f
C26 OUT a_15042_5067# 0.08548f
C27 x1.PLUS a_4841_3253# 2.47359f
C28 x1.ADJ a_13098_5067# 0.01327f
C29 OUT a_13098_5067# 0.00977f
C30 a_4841_3253# a_6294_5067# 0.00118f
C31 x1.ADJ a_11154_5067# 0.00908f
C32 OUT a_11154_5067# 0.01082f
C33 a_1315_2647# x1.MINUS 0
C34 VDD a_15685_799# 1.04905f
C35 a_6673_1001# a_15685_799# 0.21076f
C36 x1.PLUS a_5921_309# 0.25667f
C37 VDD a_7266_5067# 0.01298f
C38 x1.PLUS x1.ADJ 0.00222f
C39 x1.PLUS OUT 0
C40 x1.ADJ a_6294_5067# 0.00113f
C41 D6 D5 0.04253f
C42 a_4841_3253# a_5921_309# 0.9011f
C43 x1.ADJ a_4841_3253# 2.45499f
C44 a_4841_3253# OUT 0
C45 a_7266_5067# a_8238_5067# 0.02034f
C46 D7 D8 0.04253f
C47 x1.ADJ a_12126_5067# 0.00908f
C48 OUT a_12126_5067# 0.00944f
C49 VDD a_15042_5067# 0.0113f
C50 VDD a_13098_5067# 0.00866f
C51 x1.ADJ a_5921_309# 0
C52 OUT a_5921_309# 0.00188f
C53 VDD a_11154_5067# 0.0113f
C54 x1.ADJ a_14070_5067# 0.00908f
C55 OUT a_14070_5067# 0.02058f
C56 D2 D1 0.04253f
C57 D6 D7 0.04253f
C58 x1.ADJ OUT 7.81301f
C59 D1 OUT 0.00209f
C60 a_10182_5067# a_11154_5067# 0.02034f
C61 x1.PLUS VDD 0.75761f
C62 VDD a_6294_5067# 0.01189f
C63 VDD a_4841_3253# 6.91674f
C64 x1.PLUS a_6673_1001# 2.43165f
C65 x1.PLUS x1.MINUS 0.36388f
C66 D2 D3 0.04253f
C67 a_3265_798# VDD 0.001f
C68 x1.ADJ a_9210_5067# 0.00908f
C69 OUT a_9210_5067# 0.00932f
C70 a_15685_799# a_15042_5067# 0.0227f
C71 VDD a_12126_5067# 0.01268f
C72 a_6673_1001# a_4841_3253# 0.4474f
C73 x1.MINUS a_4841_3253# 3.19203f
C74 D0 OUT 0.02603f
C75 D1 D0 0.04594f
C76 VDD a_5921_309# 2.25955f
C77 VDD a_14070_5067# 0.01278f
C78 a_1315_2647# a_6294_5067# 0.02071f
C79 x1.ADJ VDD 25.8058f
C80 VDD OUT 47.0191f
C81 a_1315_2647# a_4841_3253# 0.04495f
C82 a_6673_1001# a_5921_309# 1.81292f
C83 x1.MINUS a_5921_309# 2.67658f
C84 x1.ADJ a_6673_1001# 0.08288f
C85 a_6673_1001# OUT 5.7359f
C86 x1.ADJ a_8238_5067# 0.00908f
C87 OUT a_8238_5067# 0.01107f
C88 x1.ADJ x1.MINUS 0.00179f
C89 x1.MINUS OUT 0.0585f
C90 x1.ADJ a_10182_5067# 0.01005f
C91 OUT a_10182_5067# 0.00924f
C92 D9 D8 0.04253f
C93 OUT VSS 44.804f
C94 D0 VSS 0.71377f
C95 D1 VSS 0.68605f
C96 D2 VSS 0.68914f
C97 D3 VSS 0.68914f
C98 D4 VSS 0.68914f
C99 D5 VSS 0.68914f
C100 D6 VSS 0.68914f
C101 D7 VSS 0.68914f
C102 D8 VSS 0.68914f
C103 D9 VSS 0.68914f
C104 D10 VSS 0.68914f
C105 D11 VSS 0.74114f
C106 VDD VSS 0.16264p
C107 a_3265_246# VSS 0.29511f
C108 a_6673_1001# VSS 19.2884f
C109 a_5921_309# VSS 5.91153f
C110 x1.PLUS VSS 1.18357f
C111 a_3265_798# VSS 0.30074f
C112 x1.MINUS VSS 1.9337f
C113 a_4841_3253# VSS 0.23676f
C114 x1.ADJ VSS 3.25984f
C115 a_15685_799# VSS 2.72106f
C116 a_15042_5067# VSS 0.79384f
C117 a_14070_5067# VSS 0.79562f
C118 a_13098_5067# VSS 0.79423f
C119 a_12126_5067# VSS 0.79562f
C120 a_11154_5067# VSS 0.79562f
C121 a_10182_5067# VSS 0.79517f
C122 a_9210_5067# VSS 0.79562f
C123 a_8238_5067# VSS 0.79562f
C124 a_7266_5067# VSS 0.79562f
C125 a_6294_5067# VSS 0.79562f
C126 a_1315_2647# VSS 3.06237f
C127 VDD.n0 VSS 0.21993f
C128 VDD.t7 VSS 15.3925f
C129 VDD.n2 VSS 4.80123f
C130 VDD.t3 VSS 19.823f
C131 VDD.n5 VSS 3.54509f
C132 VDD.n6 VSS 0.54826f
C133 VDD.n7 VSS 0.11212f
C134 VDD.n9 VSS 0.00152f
C135 VDD.n10 VSS 0.33074f
C136 VDD.n11 VSS 0.75772f
C137 VDD.n12 VSS 0.34955f
C138 VDD.n13 VSS 0.71446f
C139 VDD.t9 VSS 7.45353f
C140 VDD.t5 VSS 6.20464f
C141 VDD.t10 VSS 0.54867f
C142 VDD.t16 VSS 0.53675f
C143 VDD.t22 VSS 0.53675f
C144 VDD.t6 VSS 0.54816f
C145 VDD.t14 VSS 0.53677f
C146 VDD.n14 VSS 0.31135f
C147 VDD.t1 VSS 0.54679f
C148 VDD.t2 VSS 0.6973f
C149 VDD.t0 VSS 0.70287f
C150 VDD.t20 VSS 0.53677f
C151 VDD.t8 VSS 0.55224f
C152 VDD.t15 VSS 0.53677f
C153 VDD.t21 VSS 0.53677f
.ends
